*Memoria de uma bitcell

simulator lang=spice

.include 'TRISTATE.spi'
.include 'INV.spi'
.include 'PassTransistor.spi'
.include '45nm_LP.pm'

*Source
*enb PWL 0 1 (1n-1p) 1 1n 0 (2.5n-1p) 0 2.5n 1 (3.5n-1p) 1 3.5n 0 5.5n 0
*en PWL 0 0 (1n-1p) 0 1n 1 (2.5n-1p) 1 2.5n 0 (3.5n-1p) 0 3.5n 1 5.5n 1
*PWL 0 0 (3n-1p) 0 3n 1 (3.50n-1p) 1 3.5n

Vwl WL Gnd3 PWL 0 0 (0.7n-1p) 0 0.7n 1 (1.2n-1p) 1 1.2n 0 (1.8n-1p) 0 1.8n 1 (2.3n-1p) 1 2.3n 0 (3.4n-1p) 0 3.4n 1 (3.9n-1p) 1 3.9n 0 (5n-1p) 0 5n 1 (5.5n-1p) 1 5.5n 0
Vwdb WDB Gnd2 PWL 0 0 (0.5n-1p) 0 0.5n 1 (1.5n-1p) 1 1.5n 0.5 (2.9n-1p) 0.5 2.9n 0
Vwd WD Gnd1 PWL 0 1 (0.5n-1p) 1 0.5n 0 (1.5n-1p) 0 1.5n 0.5 (2.9n-1p) 0.5 2.9n 1
*En liga em 1  ENB em 0
Venb ENB Gnd PWL 0 1 (0.6n-1p) 1 0.6n 0 (1n-1p) 0 1n 1 (3n-1p) 1 3n 0 (3.5n+1p) 0 (3.5n+2p) 1
Ven EN Gnd PWL 0 0 (0.6n-1p) 0 0.6n 1 (1n-1p) 1 1n 0 (3n-1p) 0 3n 1 (3.5n+1p) 1 (3.5n+2p) 0

Vpre PRE Gnd4 PWL 0 1 (1.6n-1p) 1 1.6n 0 (2.1n-1p) 0 2.1n 1 (4.5n-1p) 1 4.5n 0 (5n-1p) 0 5n 1

Vvdd Vvdd Gnd5 1
Vdd Vdd Gnd 1
Vgnd Gnd 0 0
Vgnd1 Gnd1 0 0
Vgnd2 Gnd2 0 0
Vgnd3 Gnd3 0 0
Vgnd4 Gnd4 0 0
Vgnd5 Gnd5 0 0

*Bitcell
*Inversor A Y VDD VSS
X0 Q QB Vdd Gnd INV
X1 QB Q Vdd Gnd INV
*Transistor Drain Gate Source Bulk
M_i_0 BL WL Q Gnd NMOS_VTL W=0.415000U L=0.050000U
M_i_1 BLB WL QB Gnd NMOS_VTL W=0.415000U L=0.050000U

*Write cell
*TRISTATE A Y EN ENB VDD VSS
X3 WD BL EN ENB Vdd Gnd TI
X2 WDB BLB EN ENB Vdd Gnd TI

*Pre Charge
M_i_2 BL PRE Vvdd Vdd PMOS_VTL W=0.630000U L=0.050000U
M_i_3 BLB PRE Vvdd Vdd PMOS_VTL W=0.630000U L=0.050000U
M_i_4 BL PRE BLB Vdd PMOS_VTL W=0.630000U L=0.050000U

.TRAN 100p 6n

.option rawfmt="psfbin"
