* Memoria de uma bitcell

simulator lang=spice

.include '45nm_LP.pm'
.include 'MTJT.spi'
.include 'TRISTATE.spi'

.param VPre = 1
.param Vwd = 1
.param Vwdb = 0

.param TpPre = 0.5n
.param TpWl = 0.7n

Vwl WL Gnd3 PWL 0 0 '(TpWl+2p)' 0 '(TpWl+3p)' 1 (1.5n+7p) 1 (1.5n+10p) 0 '(TpWl+2p+10n)' 0 '(TpWl+3p+10n)' 1 (1.5n+7p+10n) 1 (1.5n+10p+10n) 0
Vwdb WD Gnd2 PWL 0 'Vwdb'
Vwd WDB Gnd1 PWL 0 'Vwd'
*En liga em 1  ENB em 0
Venb ENB Gnd PWL 0 1
Ven EN Gnd PWL 0 0
Vpre PRE Gnd4 PWL 0 1 '(TpPre-1p)' 1 'TpPre' 0 '(TpWl)' 0 '(TpWl+1p)' 1 '(TpPre-1p+10n)' 1 '(TpPre+10n)' 0 '(TpWl+10n)' 0 '(TpWl+1p+10n)' 1

Vvdd Vvdd Gnd 'VPre'

Vdd Vdd Gnd PWL 0 1 (3n-1p) 1 3n 0 (8n-1p) 0 8n 1 (12n-1p) 1 12n 0
Vgnd Gnd 0 0
Vgnd1 Gnd1 0 0
Vgnd2 Gnd2 0 0
Vgnd3 Gnd3 0 0
Vgnd4 Gnd4 0 0
Vgnd5 Gnd5 0 0
Vgnd6 Gnd6 0 0

* Bitcell
* Transistor Drain Gate Source Bulk
* MTJT n+ n-

*Access Transistors
M_i_0 BL WL Q Gnd NMOS W=0.415000U L=0.050000U
M_i_1 BLB WL QB Gnd NMOS W=0.415000U L=0.050000U

*Inverters
M_i_q2 Q2 QB Q Vdd PMOS W=0.630000U L=0.050000U
M_i_qb2 Q QB Q3 Gnd NMOS W=0.415000U L=0.050000U
M_i_q3 QB2 Q QB Vdd PMOS W=0.630000U L=0.050000U
M_i_qb3 QB3 Q QB Gnd NMOS W=0.415000U L=0.050000U

*MTJ PMOS
M_i_q1 Q2 QP Q1 Vdd PMOS W=0.630000U L=0.050000U
M_i_qb1 QB2 QP QB1 Vdd PMOS W=0.630000U L=0.050000U
M_i_qvdd Qvdd Gnd Vdd Vdd PMOS W=0.630000U L=0.050000U
X1 Qvdd Q1 MTJT
X2 Qvdd QB1 MTJT

* MTJ NMOS
M_i_q4 Q4 QN Q3 Gnd NMOS W=0.415000U L=0.050000U
M_i_qb4 QB4 QN QB3 Gnd NMOS W=0.415000U L=0.050000U
M_i_qgnd Gnd6 Vdd Qgnd Gnd NMOS W=0.415000U L=0.050000U
X3 Q4 Qgnd MTJT
X4 QB4 Qgnd MTJT

* Write cell
* TRISTATE A Y EN ENB VDD VSS
X5 WD BL EN ENB Vdd Gnd TI
X6 WDB BLB EN ENB Vdd Gnd TI

*Pre Charge
M_i_2 BL PRE Vvdd Vdd PMOS W=0.630000U L=0.050000U
M_i_3 BLB PRE Vvdd Vdd PMOS W=0.630000U L=0.050000U
M_i_4 BL PRE BLB Vdd PMOS W=0.630000U L=0.050000U

.TRAN 100p 20n

.option rawfmt="psfbin"
.IC V(Q)=0 V(QB)=1 V(BL)=1 V(BLB)=0
