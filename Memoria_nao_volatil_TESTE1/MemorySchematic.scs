* Memoria de uma bitcell

simulator lang=spice

.include '45nm_LP.pm'
.include 'MTJT.spi'
.include 'TRISTATE.spi'

.param Vwrite=1
.param Tp_wl=0.7n
.param Tp_en=0.6n

Vwl WL Gnd3 PWL 0 0 '(Tp_wl-1p)' 0 'Tp_wl' 1 (1n+1p) 1 (1n+2p) 0 '(Tp_wl+2.4n-1p)' 0 'Tp_wl+2.4n' 1 (3.4n+1p) 1 (3.4n+2p) 0

Vwdb WDB Gnd2 PWL 0 0 (1.5n-1p) 0 1.5n 'Vwrite'
Vwd WD Gnd1   PWL 0 'Vwrite' (1.5n-1p) 'Vwrite' 1.5n 0

Venb ENB Gnd PWL 0 1 '(Tp_en-1p)' 1 'Tp_en' 0 (1n+1p) 0 (1n+2p) 1 '(Tp_en+2.4n-1p)' 1 'Tp_en+2.4n' 0 (3.4n+1p) 0 (3.4n+2p) 1
Ven EN Gnd PWL 0 0 '(Tp_en-1p)' 0 'Tp_en' 1 (1n+1p) 1 (1n+2p) 0 '(Tp_en+2.4n-1p)' 0 'Tp_en+2.4n' 1 (3.4n+1p) 1 (3.4n+2p) 0

Vvdd Vvdd Gnd5 Vwrite
Vdd Vdd Gnd 1

Vgnd Gnd 0 0
Vgnd1 Gnd1 0 0
Vgnd2 Gnd2 0 0
Vgnd3 Gnd3 0 0
Vgnd4 Gnd4 0 0
Vgnd5 Gnd5 0 0
Vgnd6 Gnd6 0 0

* Bitcell
* Transistor Drain Gate Source Bulk
* MTJT n+ n-

*Access Transistors
M_i_0 BL WL Q Gnd NMOS W=0.415000U L=0.050000U
M_i_1 BLB WL QB Gnd NMOS W=0.415000U L=0.050000U

*Inverters
M_i_q2 Q2 QB Q Vdd PMOS W=0.630000U L=0.050000U
M_i_qb2 Q QB Q3 Gnd NMOS W=0.415000U L=0.050000U
M_i_q3 QB2 Q QB Vdd PMOS W=0.630000U L=0.050000U
M_i_qb3 QB3 Q QB Gnd NMOS W=0.415000U L=0.050000U

*MTJ PMOS
M_i_q1 Q2 QP Q1 Vdd PMOS W=0.630000U L=0.050000U
M_i_qb1 QB2 QP QB1 Vdd PMOS W=0.630000U L=0.050000U
M_i_qvdd Qvdd Gnd Vdd Vdd PMOS W=0.630000U L=0.050000U
X1 Qvdd Q1 MTJT
X2 Qvdd QB1 MTJT

* MTJ NMOS
M_i_q4 Q4 QN Q3 Gnd NMOS W=0.415000U L=0.050000U
M_i_qb4 QB4 QN QB3 Gnd NMOS W=0.415000U L=0.050000U
M_i_qgnd Gnd6 Vdd Qgnd Gnd NMOS W=0.415000U L=0.050000U
X3 Q4 Qgnd MTJT
X4 QB4 Qgnd MTJT

* Write cell
* TRISTATE A Y EN ENB VDD VSS
X5 WD BL EN ENB Vdd Gnd TI
X6 WDB BLB EN ENB Vdd Gnd TI

*Pre Charge
M_i_2 BL PRE Vdd Vdd PMOS W=0.630000U L=0.050000U
M_i_3 BLB PRE Vdd Vdd PMOS W=0.630000U L=0.050000U
M_i_4 BL PRE BLB Vdd PMOS W=0.630000U L=0.050000U

.TRAN 100p 4n

.option rawfmt="psfbin"
