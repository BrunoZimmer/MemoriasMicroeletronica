* Crossbar one bit

simulator lang=spice

.include '45nm_LP.pm'
.include 'MTJT.spi'
.include 'TRANSGATE.spi'

*pra escrever precisa de uma ddp de 0.9 e pra ler -0.36
.param cap = 5f

.param Vvdd = 1.6

.param Vgnd = 0

.param Vread = 0.8

.param TpWrite = 0.9n
.param TpRead = 0.1n
.param TpPulse = 1n

* Wordlines controller
Vwl1 WL1 Gnd PWL 0 'Vgnd'

*Bitlines controller
Vbl1 BL1T Gnd PWL 0 'Vgnd' 'TpWrite+5n-1p' 'Vgnd' 'TpWrite+5n' 'Vvdd' 'TpWrite+5n+TpPulse' 'Vvdd' 'TpWrite+5n+TpPulse+1p' 'Vgnd'
Vsl1 SL1 Gnd PWL 0 'Vgnd' 'TpRead-1p' 'Vgnd' 'TpRead' 'Vvdd' 'TpRead+TpPulse' 'Vvdd' 'TpRead+TpPulse+1p' 'Vgnd' '8n-1p+TpRead' 'Vgnd' '8n+TpRead' 'Vread' '8n+0.8n' 'Vread' '8n+0.8n+1p' 'Vgnd'

Vbl1en ENBl1 Gnd PWL 0 'Vvdd'

Vtest BL1T BL1 0

Vdd Vdd Gnd 'Vvdd'

*Transistor Drain Gate Source Bulk
* Bitcell
X1 NM1 BL1 MTJT
M_i_1 NM1 WL1 SL1 SL1 PMOS W=12.630000U L=0.050000U

*Tristate
*X5 SL1T SL1 ENBl1 Vdd Gnd TG
*X6 BL1T BL1U ENBl1 Vdd Gnd TG

*Bitlines Capacitance
Cbl1 BL1 Gnd 'cap'

.TRAN 1p 10n

.option rawfmt="psfbin"
